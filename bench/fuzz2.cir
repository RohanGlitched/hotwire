* Two-transistor fuzz (silicon NPN, fuzz-face style)
*@ title Two-transistor fuzz
*@ in VIN
*@ out out
*@ supply VCC
VCC vcc 0 9
VIN in 0 0
RS in g 10k
C1 g b1 2.2u
Q1 c1 b1 0 BC549C
R1 vcc c1 33k
Q2 c2 c1 e2 BC549C
R3 vcc c2 8.2k
R5 e2 b1 100k
RE e2 0 1k
CE e2 0 22u
R4 c2 o1 470
C3 o1 out 10n
RL out 0 500k
