* Hotwire ngspice deck (op + ac) for library/inductor_wah.cir: Inductor wah band-pass
* Generated by tests/test_library_ngspice.py; do not edit by hand.
RV1_A 0 pw 500
RV1_B pw pb 500
VIN in 0 DC 0 AC 1
VCC vcc 0 DC 9
RPD in 0 1meg
C1 in x 100n
R1 x b 33k
RB1 vcc b 82k
RB2 b 0 15k
Q1 c b e BC549C
RE1 e e2 470
RE2 e2 0 2k
CE e2 0 47u
RC vcc c 15k
L1 c lb 500m
CL lb vcc 22u
Q2 vcc c e3 BC549C
RE3 e3 0 2.2k
C4 e3 pb 22u
CT pw c 220n
C5 e3 out 1u
RL out 0 100k
.model BC549C NPN(IS=2.39e-14 BF=520 BR=10 NF=1.008 NR=1 VAF=80 RB=10 RC=1 RE=0 CJE=1.15e-11 VJE=0.75 MJE=0.33 CJC=5.25e-12 VJC=0.75 MJC=0.33)
.control
set noaskquit
set filetype=ascii
set wr_vecnames
set wr_singlescale
set numdgt=12
op
print all
print @q1[ic] @q1[ib] @q1[vbe] @q1[vbc] @q2[ic] @q2[ib] @q2[vbe] @q2[vbc]
ac dec 100 1 200000
let hr = real(v(out)/v(in))
let hi = imag(v(out)/v(in))
wrdata ac.txt hr hi
.endc
.end
