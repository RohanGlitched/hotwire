* Hotwire ngspice deck (op + ac) for library/mosfet_boost.cir: MOSFET clean boost
* Generated by tests/test_library_ngspice.py; do not edit by hand.
RV1_A 0 out 100000
RV1_B out o 1
VIN in 0 DC 0 AC 1
VCC vcc 0 DC 9
RPD in 0 1meg
C1 in g 100n
R1 vcc g 1.5meg
R2 g 0 1meg
M1 d g s s BS170
RD vcc d 4.7k
RS1 s s2 470
RS2 s2 0 1.3k
CS s2 0 47u
C2 d o 1u
.model BS170 NMOS(LEVEL=1 VTO=2 KP=0.25 LAMBDA=0.01 RD=0.7 IS=1e-15 CBD=5.5e-11 PB=0.8 MJ=0.5 CGSO=1.7e-07 CGDO=7e-08)
.control
set noaskquit
set filetype=ascii
set wr_vecnames
set wr_singlescale
set numdgt=12
op
print all
print @m1[id] @m1[vgs] @m1[vds]
ac dec 100 1 200000
let hr = real(v(out)/v(in))
let hi = imag(v(out)/v(in))
wrdata ac.txt hr hi
.endc
.end
