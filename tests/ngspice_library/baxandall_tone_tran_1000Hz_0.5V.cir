* Hotwire ngspice deck (tran 1000 Hz, 0.5 V peak) for library/baxandall_tone.cir: Baxandall active bass and treble control
* Generated by tests/test_library_ngspice.py; do not edit by hand.
RVB_A bb bw 50000
RVB_B bw ba 50000
RVT_A tb tw 50000
RVT_B tw ta 50000
BVIN in 0 V=0.5*min(1,time/0.005)*sin(6283.185307*time)
VCC vcc 0 DC 9
RPD in 0 1meg
CIN in i 10u
RREF1 vcc vref 10k
RREF2 vref 0 10k
CREF vref 0 47u
R1 i ba 10k
R2 bb o 10k
C1 ba bw 22n
C2 bw bb 22n
R3 bw n 10k
C3 i ta 4.7n
C4 tb o 4.7n
RTW tw n 3.3k
XU1 vref n vcc 0 o HWOA_NE5532
COUT o out 10u
RL out 0 100k
.subckt HWOA_NE5532 inp inn vcc vee out
Rin inp inn 300000
G1 0 n1 inp inn 0.1
R1 n1 0 1000000
C1 n1 0 1.591549431e-09
Bcl n1 0 I=1000.0*(((v(n1)-(v(vcc)-2))>0 ? (v(n1)-(v(vcc)-2))+0.01*ln(1+exp(-(v(n1)-(v(vcc)-2))/0.01)) : 0.01*ln(1+exp((v(n1)-(v(vcc)-2))/0.01)))-(((v(vee)+2)-v(n1))>0 ? ((v(vee)+2)-v(n1))+0.01*ln(1+exp(-((v(vee)+2)-v(n1))/0.01)) : 0.01*ln(1+exp(((v(vee)+2)-v(n1))/0.01))))
E1 ob 0 n1 0 1
Ro ob out 30
Iq vcc vee DC 0.004
.ends
.control
set noaskquit
set filetype=ascii
set wr_vecnames
set wr_singlescale
set numdgt=12
tran 5e-06 0.08 0 5e-06
wrdata tran.txt v(out)
.endc
.end
