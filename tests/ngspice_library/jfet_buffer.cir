* Hotwire ngspice deck (op + ac) for library/jfet_buffer.cir: JFET input buffer
* Generated by tests/test_library_ngspice.py; do not edit by hand.
VIN in 0 DC 0 AC 1
VCC vcc 0 DC 9
RPD in 0 2.2meg
C1 in g 100n
RG g vb 1meg
RB1 vcc vb 1meg
RB2 vb 0 1meg
CB vb 0 10u
RD vcc d 100
CD d 0 47u
J1 d g s J201
RS s 0 22k
C2 s out 1u
RL out 0 100k
.model J201 NJF(VTO=-0.7 BETA=0.001 LAMBDA=0.005 IS=1e-14 CGS=4e-12 CGD=3e-12 PB=1)
.control
set noaskquit
set filetype=ascii
set wr_vecnames
set wr_singlescale
set numdgt=12
op
print all
print @j1[id] @j1[vgs] @j1[vgd]
ac dec 100 1 200000
let hr = real(v(out)/v(in))
let hi = imag(v(out)/v(in))
wrdata ac.txt hr hi
.endc
.end
