* Hotwire ngspice deck (op + ac) for library/jfet_boost.cir: JFET clean boost
* Generated by tests/test_library_ngspice.py; do not edit by hand.
RV1_A 0 out 100000
RV1_B out o 1
VIN in 0 DC 0 AC 1
VCC vcc 0 DC 9
RPD in 0 1meg
C1 in g 100n
RG g 0 1meg
J1 d g s MPF102
RD vcc d 4.7k
RS1 s s2 100
RS2 s2 0 2k
CS s2 0 47u
C2 d o 1u
.model MPF102 NJF(VTO=-3 BETA=0.0006 LAMBDA=0.02 IS=1e-14 CGS=4e-12 CGD=3e-12 PB=1)
.control
set noaskquit
set filetype=ascii
set wr_vecnames
set wr_singlescale
set numdgt=12
op
print all
print @j1[id] @j1[vgs] @j1[vgd]
ac dec 100 1 200000
let hr = real(v(out)/v(in))
let hi = imag(v(out)/v(in))
wrdata ac.txt hr hi
.endc
.end
