* Hotwire ngspice deck (tran 500 Hz, 0.2 V peak) for library/octave_fuzz.cir: Octave-up rectifier fuzz
* Generated by tests/test_library_ngspice.py; do not edit by hand.
RV1_A 0 out 76547.27864
RV1_B out sv 23452.72136
BVIN in 0 V=0.2*min(1,time/0.005)*sin(3141.592654*time)
VCC vcc 0 DC 9
RPD in 0 1meg
C1 in b1 1u
RB1 vcc b1 100k
RB2 b1 0 22k
Q1 c1 b1 e1 2N3904
RC1 vcc c1 4.7k
RE1 e1 e1b 470
RE1B e1b 0 470
CE1 e1b 0 47u
C2 c1 b2 1u
RB3 vcc b2 47k
RB4 b2 0 22k
Q2 c2 b2 e2 2N3904
RC2 vcc c2 4.7k
RE2 e2 0 4.7k
C3 c2 da 1u
C4 e2 eb 1u
RBAL eb db 4.7k
RA da 0 100k
RBB db 0 100k
D1 da s 1N34A
D2 db s 1N34A
RS s 0 22k
C5 s sv 1u
.model 1N34A D(IS=2e-07 N=1.3 RS=5 CJO=1e-12 VJ=0.5 M=0.5)
.model 2N3904 NPN(IS=6.734e-15 BF=134 BR=0.7371 NF=1 NR=1 VAF=74.03 RB=10 RC=1 RE=0 CJE=4.493e-12 VJE=0.75 MJE=0.2593 CJC=3.638e-12 VJC=0.75 MJC=0.3085)
.control
set noaskquit
set filetype=ascii
set wr_vecnames
set wr_singlescale
set numdgt=12
tran 1e-05 0.08 0 1e-05
wrdata tran.txt v(out)
.endc
.end
