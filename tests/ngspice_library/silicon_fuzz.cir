* Hotwire ngspice deck (op + ac) for library/silicon_fuzz.cir: Two-transistor silicon fuzz
* Generated by tests/test_library_ngspice.py; do not edit by hand.
RV1_A 0 fw 1000
RV1_B fw e2 1
RV2_A 0 out 115831.2395
RV2_B out o 384168.7605
VIN in 0 DC 0 AC 1
VCC vcc 0 DC 9
RPD in 0 1meg
C1 in b1 2.2u
Q1 c1 b1 0 2N3904
R1 vcc c1 33k
Q2 c2 c1 e2 2N3904
RF e2 b1 100k
CF fw 0 22u
R3 vcc r34 4.7k
R4 r34 c2 470
C3 c2 o 10n
.model 2N3904 NPN(IS=6.734e-15 BF=134 BR=0.7371 NF=1 NR=1 VAF=74.03 RB=10 RC=1 RE=0 CJE=4.493e-12 VJE=0.75 MJE=0.2593 CJC=3.638e-12 VJC=0.75 MJC=0.3085)
.control
set noaskquit
set filetype=ascii
set wr_vecnames
set wr_singlescale
set numdgt=12
op
print all
print @q1[ic] @q1[ib] @q1[vbe] @q1[vbc] @q2[ic] @q2[ib] @q2[vbe] @q2[vbc]
ac dec 100 1 200000
let hr = real(v(out)/v(in))
let hi = imag(v(out)/v(in))
wrdata ac.txt hr hi
.endc
.end
