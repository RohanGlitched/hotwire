* Hotwire ngspice deck (op + ac) for library/passive_tone_stack.cir: Three-knob passive amp tone stack
* Generated by tests/test_library_ngspice.py; do not edit by hand.
RVT_A b1 out 57915.61976
RVT_B out t 192084.3802
RVB_A b1 m 231662.479
RVB_B m m 768337.521
RVM_A m 0 12500
RVM_B 0 0 12500
VIN in 0 DC 0 AC 1
C1 in t 470p
R1 in n 33k
C2 n b1 22n
C3 n m 22n
RL out 0 1meg
.control
set noaskquit
set filetype=ascii
set wr_vecnames
set wr_singlescale
set numdgt=12
op
print all
ac dec 100 1 200000
let hr = real(v(out)/v(in))
let hi = imag(v(out)/v(in))
wrdata ac.txt hr hi
.endc
.end
