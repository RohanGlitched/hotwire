* Hotwire ngspice deck (op + ac) for library/treble_booster.cir: Germanium treble booster
* Generated by tests/test_library_ngspice.py; do not edit by hand.
RV1_A 0 w 10000
RV1_B w c 1
VIN in 0 DC 0 AC 1
VCC vcc 0 DC 9
RPD in 0 1meg
C1 in b 4.7n
RB1 vcc b 68k
RB2 b 0 470k
Q1 c b e AC128
RE vcc e 3.9k
CE vcc e 47u
C2 w out 10n
RL out 0 1meg
.model AC128 PNP(IS=3e-07 BF=90 BR=5 NF=1 NR=1 VAF=30 RB=50 RC=1 RE=0 CJE=1e-10 VJE=0.4 MJE=0.33 CJC=4e-11 VJC=0.4 MJC=0.33)
.control
set noaskquit
set filetype=ascii
set wr_vecnames
set wr_singlescale
set numdgt=12
op
print all
print @q1[ic] @q1[ib] @q1[vbe] @q1[vbc]
ac dec 100 1 200000
let hr = real(v(out)/v(in))
let hi = imag(v(out)/v(in))
wrdata ac.txt hr hi
.endc
.end
