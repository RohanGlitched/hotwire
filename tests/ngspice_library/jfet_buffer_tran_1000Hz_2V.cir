* Hotwire ngspice deck (tran 1000 Hz, 2 V peak) for library/jfet_buffer.cir: JFET input buffer
* Generated by tests/test_library_ngspice.py; do not edit by hand.
BVIN in 0 V=2*min(1,time/0.005)*sin(6283.185307*time)
VCC vcc 0 DC 9
RPD in 0 2.2meg
C1 in g 100n
RG g vb 1meg
RB1 vcc vb 1meg
RB2 vb 0 1meg
CB vb 0 10u
RD vcc d 100
CD d 0 47u
J1 d g s J201
RS s 0 22k
C2 s out 1u
RL out 0 100k
.model J201 NJF(VTO=-0.7 BETA=0.001 LAMBDA=0.005 IS=1e-14 CGS=4e-12 CGD=3e-12 PB=1)
.control
set noaskquit
set filetype=ascii
set wr_vecnames
set wr_singlescale
set numdgt=12
tran 5e-06 0.08 0 5e-06
wrdata tran.txt v(out)
.endc
.end
