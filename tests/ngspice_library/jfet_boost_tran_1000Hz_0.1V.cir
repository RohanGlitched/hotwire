* Hotwire ngspice deck (tran 1000 Hz, 0.1 V peak) for library/jfet_boost.cir: JFET clean boost
* Generated by tests/test_library_ngspice.py; do not edit by hand.
RV1_A 0 out 100000
RV1_B out o 1
BVIN in 0 V=0.1*min(1,time/0.005)*sin(6283.185307*time)
VCC vcc 0 DC 9
RPD in 0 1meg
C1 in g 100n
RG g 0 1meg
J1 d g s MPF102
RD vcc d 4.7k
RS1 s s2 100
RS2 s2 0 2k
CS s2 0 47u
C2 d o 1u
.model MPF102 NJF(VTO=-3 BETA=0.0006 LAMBDA=0.02 IS=1e-14 CGS=4e-12 CGD=3e-12 PB=1)
.control
set noaskquit
set filetype=ascii
set wr_vecnames
set wr_singlescale
set numdgt=12
tran 5e-06 0.08 0 5e-06
wrdata tran.txt v(out)
.endc
.end
