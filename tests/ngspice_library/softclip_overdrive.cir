* Hotwire ngspice deck (op + ac) for library/softclip_overdrive.cir: Op-amp soft-clip overdrive
* Generated by tests/test_library_ngspice.py; do not edit by hand.
RV1_A f n 115831.2395
RV1_B n n 384168.7605
RV2_A ta tw 10000
RV2_B tw tb 10000
RV3_A 0 out 43576.56669
RV3_B out c 56423.43331
VIN in 0 DC 0 AC 1
VCC vcc 0 DC 9
RPD in 0 1meg
C1 in p 22n
RB p vref 1meg
RREF1 vcc vref 10k
RREF2 vref 0 10k
CREF vref 0 47u
XU1 p n vcc 0 o1 HWOA_RC4558
RF1 o1 f 51k
CF o1 n 51p
D1 o1 n 1N914
D2 n o1 1N914
RG n g 4.7k
CG g vref 47n
R7 o1 t1 1k
C5 t1 vref 220n
R8 t1 ta 220
C6 tw vref 220n
R9 tb n2 1k
XU2 t1 n2 vcc 0 o2 HWOA_RC4558
R11 o2 n2 1k
C7 o2 c 1u
.model 1N914 D(IS=2.52e-09 N=1.752 RS=0.568 CJO=4e-12 VJ=1 M=0.4)
.subckt HWOA_RC4558 inp inn vcc vee out
Rin inp inn 5000000
G1 0 n1 inp inn 0.3
R1 n1 0 1000000
C1 n1 0 1.591549431e-08
Bcl n1 0 I=1000.0*(((v(n1)-(v(vcc)-1))>0 ? (v(n1)-(v(vcc)-1))+0.01*ln(1+exp(-(v(n1)-(v(vcc)-1))/0.01)) : 0.01*ln(1+exp((v(n1)-(v(vcc)-1))/0.01)))-(((v(vee)+1)-v(n1))>0 ? ((v(vee)+1)-v(n1))+0.01*ln(1+exp(-((v(vee)+1)-v(n1))/0.01)) : 0.01*ln(1+exp(((v(vee)+1)-v(n1))/0.01))))
E1 ob 0 n1 0 1
Ro ob out 75
Iq vcc vee DC 0.00125
.ends
.control
set noaskquit
set filetype=ascii
set wr_vecnames
set wr_singlescale
set numdgt=12
op
print all
print @d1[id] @d2[id]
ac dec 100 1 200000
let hr = real(v(out)/v(in))
let hi = imag(v(out)/v(in))
wrdata ac.txt hr hi
.endc
.end
