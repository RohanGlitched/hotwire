* Hotwire ngspice deck (tran 1000 Hz, 0.0666761 V peak) for library/ce_amplifier.cir: Common-emitter amplifier with emitter degeneration
* Generated by tests/test_library_ngspice.py; do not edit by hand.
BVIN in 0 V=0.06667607161*min(1,time/0.005)*sin(6283.185307*time)
VCC vcc 0 DC 9
C1 in b 1u
R1 vcc b 47k
R2 b 0 10k
Q1 c b e 2N3904
RC vcc c 4.7k
RE1 e e2 220
RE2 e2 0 820
CE e2 0 100u
C2 c out 1u
RL out 0 100k
.model 2N3904 NPN(IS=6.734e-15 BF=134 BR=0.7371 NF=1 NR=1 VAF=74.03 RB=10 RC=1 RE=0 CJE=4.493e-12 VJE=0.75 MJE=0.2593 CJC=3.638e-12 VJC=0.75 MJC=0.3085)
.control
set noaskquit
set filetype=ascii
set wr_vecnames
set wr_singlescale
set numdgt=12
tran 5e-06 0.08 0 5e-06
wrdata tran.txt v(out)
.endc
.end
