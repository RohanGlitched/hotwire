* Hotwire ngspice deck (tran 1000 Hz, 1 V peak) for library/sallen_key_lowpass.cir: Sallen-Key low-pass filter (1 kHz Butterworth)
* Generated by tests/test_library_ngspice.py; do not edit by hand.
BVIN in 0 V=1*min(1,time/0.005)*sin(6283.185307*time)
VCC vcc 0 DC 9
RPD in 0 1meg
CIN in a 1u
RB a vref 100k
RREF1 vcc vref 10k
RREF2 vref 0 10k
CREF vref 0 47u
R1 a b 10k
R2 b c 10k
C1 b fo 22n
C2 c 0 10n
XU1 c fo vcc 0 fo HWOA_TL072
COUT fo out 1u
RL out 0 100k
.subckt HWOA_TL072 inp inn vcc vee out
Rin inp inn 1e+12
G1 0 n1 inp inn 0.2
R1 n1 0 1000000
C1 n1 0 1.061032954e-08
Bcl n1 0 I=1000.0*(((v(n1)-(v(vcc)-1.5))>0 ? (v(n1)-(v(vcc)-1.5))+0.01*ln(1+exp(-(v(n1)-(v(vcc)-1.5))/0.01)) : 0.01*ln(1+exp((v(n1)-(v(vcc)-1.5))/0.01)))-(((v(vee)+1.5)-v(n1))>0 ? ((v(vee)+1.5)-v(n1))+0.01*ln(1+exp(-((v(vee)+1.5)-v(n1))/0.01)) : 0.01*ln(1+exp(((v(vee)+1.5)-v(n1))/0.01))))
E1 ob 0 n1 0 1
Ro ob out 75
Iq vcc vee DC 0.0014
.ends
.control
set noaskquit
set filetype=ascii
set wr_vecnames
set wr_singlescale
set numdgt=12
tran 5e-06 0.08 0 5e-06
wrdata tran.txt v(out)
.endc
.end
