* Hotwire ngspice deck (op + ac) for library/germanium_fuzz.cir: Two-transistor germanium fuzz
* Generated by tests/test_library_ngspice.py; do not edit by hand.
RV1_A vcc fw 1000
RV1_B fw e2 1
RV2_A 0 out 115831.2395
RV2_B out o 384168.7605
VIN in 0 DC 0 AC 1
VCC vcc 0 DC 9
RPD in 0 1meg
C1 in b1 2.2u
Q1 c1 b1 vcc AC128
R1 c1 0 33k
Q2 c2 c1 e2 AC128
RF e2 b1 100k
CF fw vcc 22u
R4 c2 r34 470
R3 r34 0 8.2k
C3 c2 o 10n
.model AC128 PNP(IS=3e-07 BF=90 BR=5 NF=1 NR=1 VAF=30 RB=50 RC=1 RE=0 CJE=1e-10 VJE=0.4 MJE=0.33 CJC=4e-11 VJC=0.4 MJC=0.33)
.control
set noaskquit
set filetype=ascii
set wr_vecnames
set wr_singlescale
set numdgt=12
op
print all
print @q1[ic] @q1[ib] @q1[vbe] @q1[vbc] @q2[ic] @q2[ib] @q2[vbe] @q2[vbc]
ac dec 100 1 200000
let hr = real(v(out)/v(in))
let hi = imag(v(out)/v(in))
wrdata ac.txt hr hi
.endc
.end
