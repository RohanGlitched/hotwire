* Hotwire ngspice deck (op + ac) for library/rc_lowpass.cir: RC low-pass filter (1 kHz)
* Generated by tests/test_library_ngspice.py; do not edit by hand.
VIN in 0 DC 0 AC 1
R1 in out 10k
C1 out 0 15n
.control
set noaskquit
set filetype=ascii
set wr_vecnames
set wr_singlescale
set numdgt=12
op
print all
ac dec 100 1 200000
let hr = real(v(out)/v(in))
let hi = imag(v(out)/v(in))
wrdata ac.txt hr hi
.endc
.end
