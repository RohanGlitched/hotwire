* Hotwire ngspice deck (free-running tran) for library/wien_oscillator.cir: Wien-bridge sine oscillator (1 kHz)
* Generated by tests/test_library_ngspice.py; do not edit by hand.
VCC vcc 0 DC 9
RREF1 vcc vref 10k
RREF2 vref 0 10k
CREF vref 0 47u ic=4.5
R1 o s 16k
C1 s p 10n ic=0.1
R2 p vref 16k
C2 p vref 10n
XU1 p n vcc 0 o HWOA_TL072
RG n vref 10k
RF1 o f 13k
RF2 f n 7.5k
D1 f n 1N4148
D2 n f 1N4148
COUT o out 1u ic=4.5
RL out 0 100k
.model 1N4148 D(IS=2.52e-09 N=1.752 RS=0.568 CJO=4e-12 VJ=1 M=0.4)
.subckt HWOA_TL072 inp inn vcc vee out
Rin inp inn 1e+12
G1 0 n1 inp inn 0.2
R1 n1 0 1000000
C1 n1 0 1.061032954e-08
Bcl n1 0 I=1000.0*(((v(n1)-(v(vcc)-1.5))>0 ? (v(n1)-(v(vcc)-1.5))+0.01*ln(1+exp(-(v(n1)-(v(vcc)-1.5))/0.01)) : 0.01*ln(1+exp((v(n1)-(v(vcc)-1.5))/0.01)))-(((v(vee)+1.5)-v(n1))>0 ? ((v(vee)+1.5)-v(n1))+0.01*ln(1+exp(-((v(vee)+1.5)-v(n1))/0.01)) : 0.01*ln(1+exp(((v(vee)+1.5)-v(n1))/0.01))))
E1 ob 0 n1 0 1
Ro ob out 75
Iq vcc vee DC 0.0014
.ends
.control
set noaskquit
set filetype=ascii
set wr_vecnames
set wr_singlescale
set numdgt=12
tran 2e-06 0.2 0 2e-06 uic
wrdata tran.txt v(out)
.endc
.end
