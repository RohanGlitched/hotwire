* Hotwire ngspice deck (tran 1000 Hz, 0.2 V peak) for library/diode_hard_clipper.cir: Silicon diode hard clipper
* Generated by tests/test_library_ngspice.py; do not edit by hand.
RV1_A y y 894686.3586
RV1_B y x 105313.6414
RV2_A 0 out 43576.56669
RV2_B out clip 56423.43331
BVIN in 0 V=0.2*min(1,time/0.005)*sin(6283.185307*time)
VCC vcc 0 DC 9
RPD in 0 1meg
C1 in p 10n
RB p vref 1meg
RREF1 vcc vref 10k
RREF2 vref 0 10k
CREF vref 0 47u
XU1 p n vcc 0 o HWOA_TL071
RF o n 1meg
RG n x 4.7k
CG y 0 47n
C2 o c 1u
R2 c clip 10k
D1 clip 0 1N4148
D2 0 clip 1N4148
C3 clip 0 1n
.model 1N4148 D(IS=2.52e-09 N=1.752 RS=0.568 CJO=4e-12 VJ=1 M=0.4)
.subckt HWOA_TL071 inp inn vcc vee out
Rin inp inn 1e+12
G1 0 n1 inp inn 0.2
R1 n1 0 1000000
C1 n1 0 1.061032954e-08
Bcl n1 0 I=1000.0*(((v(n1)-(v(vcc)-1.5))>0 ? (v(n1)-(v(vcc)-1.5))+0.01*ln(1+exp(-(v(n1)-(v(vcc)-1.5))/0.01)) : 0.01*ln(1+exp((v(n1)-(v(vcc)-1.5))/0.01)))-(((v(vee)+1.5)-v(n1))>0 ? ((v(vee)+1.5)-v(n1))+0.01*ln(1+exp(-((v(vee)+1.5)-v(n1))/0.01)) : 0.01*ln(1+exp(((v(vee)+1.5)-v(n1))/0.01))))
E1 ob 0 n1 0 1
Ro ob out 75
Iq vcc vee DC 0.0014
.ends
.control
set noaskquit
set filetype=ascii
set wr_vecnames
set wr_singlescale
set numdgt=12
tran 5e-06 0.08 0 5e-06
wrdata tran.txt v(out)
.endc
.end
