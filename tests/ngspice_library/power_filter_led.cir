* Hotwire ngspice deck (op + ac) for library/power_filter_led.cir: 9 V power filter with polarity protection and LED
* Generated by tests/test_library_ngspice.py; do not edit by hand.
VCC raw 0 DC 9
VIN in raw DC 0 AC 1
D1 in a 1N5817
R1 a out 47
C1 out 0 470u
C2 out 0 100n
RLED out l 4.7k
D2 l 0 LED_RED
RLOAD out 0 1.8k
.model 1N5817 D(IS=3.17e-05 N=1.373 RS=0.051 CJO=1.9e-10 VJ=1 M=0.3)
.model LED_RED D(IS=9.32e-11 N=3.73 RS=0.042 CJO=2.97e-12 VJ=0.75 M=0.333)
.control
set noaskquit
set filetype=ascii
set wr_vecnames
set wr_singlescale
set numdgt=12
op
print all
print @d1[id] @d2[id]
ac dec 100 1 200000
let hr = real(v(out)/(v(in)-v(raw)))
let hi = imag(v(out)/(v(in)-v(raw)))
wrdata ac.txt hr hi
.endc
.end
