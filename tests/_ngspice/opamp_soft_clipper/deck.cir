* Non-inverting op-amp with diodes in the feedback loop (generated for the Hotwire cross-check)
VCC vcc 0 DC 9
VEE vee 0 DC -9
VIN in 0 DC 0 AC 1 SIN(0 0.2 500 0 0)
X1 in fb vcc vee out OA_0
RF out fb 220000
CF out fb 5.1e-11
D1 out fb D1N4148
D2 fb out D1N4148
RG fb g 4700
CG g 0 4.7e-08
.model D1N4148 D(IS=2.52e-09 N=1.752 RS=0.568 CJO=4e-12 M=0.4 TT=1.15e-08)
.subckt OA_0 inp inn vcc vee out
Rin inp inn 1e+12
G1 0 p inp inn 200
Rp p 0 1000
Cp p 0 1.06103295395e-05
Bcl p 0 I=3000*(((v(p)-(((v(vcc)-1.5)+(v(vee)+1.5))/2)-4*max(((v(vcc)-1.5)-(v(vee)+1.5))/2,0.01))>0 ? (v(p)-(((v(vcc)-1.5)+(v(vee)+1.5))/2)-4*max(((v(vcc)-1.5)-(v(vee)+1.5))/2,0.01))+0.01*ln(1+exp(-(v(p)-(((v(vcc)-1.5)+(v(vee)+1.5))/2)-4*max(((v(vcc)-1.5)-(v(vee)+1.5))/2,0.01))/0.01)) : 0.01*ln(1+exp((v(p)-(((v(vcc)-1.5)+(v(vee)+1.5))/2)-4*max(((v(vcc)-1.5)-(v(vee)+1.5))/2,0.01))/0.01)))-(((((v(vcc)-1.5)+(v(vee)+1.5))/2)-4*max(((v(vcc)-1.5)-(v(vee)+1.5))/2,0.01)-v(p))>0 ? ((((v(vcc)-1.5)+(v(vee)+1.5))/2)-4*max(((v(vcc)-1.5)-(v(vee)+1.5))/2,0.01)-v(p))+0.01*ln(1+exp(-((((v(vcc)-1.5)+(v(vee)+1.5))/2)-4*max(((v(vcc)-1.5)-(v(vee)+1.5))/2,0.01)-v(p))/0.01)) : 0.01*ln(1+exp(((((v(vcc)-1.5)+(v(vee)+1.5))/2)-4*max(((v(vcc)-1.5)-(v(vee)+1.5))/2,0.01)-v(p))/0.01))))
Bo o 0 V=(((v(vcc)-1.5)+(v(vee)+1.5))/2)+max(((v(vcc)-1.5)-(v(vee)+1.5))/2,0.01)*tanh((v(p)-(((v(vcc)-1.5)+(v(vee)+1.5))/2))/max(((v(vcc)-1.5)-(v(vee)+1.5))/2,0.01))
Ro o out 75
Iq vcc vee 0.0014
.ends
.options rshunt=1e12 reltol=1e-6 abstol=1e-15 vntol=1e-9 itl1=500 itl4=200
.control
set wr_singlescale
set wr_vecnames
option numdgt=12
op
wrdata <repo>/tests/_ngspice/opamp_soft_clipper/op.txt v(vcc) v(vee) v(in) v(fb) v(out) v(g)
ac dec 20 10 1000000
wrdata <repo>/tests/_ngspice/opamp_soft_clipper/ac.txt v(out)
tran 5e-06 0.006 0 5e-06
linearize v(vcc) v(vee) v(in) v(fb) v(out) v(g)
wrdata <repo>/tests/_ngspice/opamp_soft_clipper/tran.txt v(vcc) v(vee) v(in) v(fb) v(out) v(g)
.endc
.end
