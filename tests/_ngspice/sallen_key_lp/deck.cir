* Unity-gain Sallen-Key low-pass, about 1.07 kHz (generated for the Hotwire cross-check)
VCC vcc 0 DC 9
VEE vee 0 DC -9
VIN in 0 DC 0 AC 1 SIN(0 0.5 1000 0 0)
R1 in a 10000
R2 a p 10000
C1 a out 2.2e-08
C2 p 0 1e-08
X1 p out vcc vee out OA_0
.subckt OA_0 inp inn vcc vee out
Rin inp inn 1e+12
G1 0 p inp inn 200
Rp p 0 1000
Cp p 0 1.06103295395e-05
Bcl p 0 I=3000*(((v(p)-(((v(vcc)-1.5)+(v(vee)+1.5))/2)-4*max(((v(vcc)-1.5)-(v(vee)+1.5))/2,0.01))>0 ? (v(p)-(((v(vcc)-1.5)+(v(vee)+1.5))/2)-4*max(((v(vcc)-1.5)-(v(vee)+1.5))/2,0.01))+0.01*ln(1+exp(-(v(p)-(((v(vcc)-1.5)+(v(vee)+1.5))/2)-4*max(((v(vcc)-1.5)-(v(vee)+1.5))/2,0.01))/0.01)) : 0.01*ln(1+exp((v(p)-(((v(vcc)-1.5)+(v(vee)+1.5))/2)-4*max(((v(vcc)-1.5)-(v(vee)+1.5))/2,0.01))/0.01)))-(((((v(vcc)-1.5)+(v(vee)+1.5))/2)-4*max(((v(vcc)-1.5)-(v(vee)+1.5))/2,0.01)-v(p))>0 ? ((((v(vcc)-1.5)+(v(vee)+1.5))/2)-4*max(((v(vcc)-1.5)-(v(vee)+1.5))/2,0.01)-v(p))+0.01*ln(1+exp(-((((v(vcc)-1.5)+(v(vee)+1.5))/2)-4*max(((v(vcc)-1.5)-(v(vee)+1.5))/2,0.01)-v(p))/0.01)) : 0.01*ln(1+exp(((((v(vcc)-1.5)+(v(vee)+1.5))/2)-4*max(((v(vcc)-1.5)-(v(vee)+1.5))/2,0.01)-v(p))/0.01))))
Bo o 0 V=(((v(vcc)-1.5)+(v(vee)+1.5))/2)+max(((v(vcc)-1.5)-(v(vee)+1.5))/2,0.01)*tanh((v(p)-(((v(vcc)-1.5)+(v(vee)+1.5))/2))/max(((v(vcc)-1.5)-(v(vee)+1.5))/2,0.01))
Ro o out 75
Iq vcc vee 0.0014
.ends
.options rshunt=1e12 reltol=1e-6 abstol=1e-15 vntol=1e-9 itl1=500 itl4=200
.control
set wr_singlescale
set wr_vecnames
option numdgt=12
op
wrdata <repo>/tests/_ngspice/sallen_key_lp/op.txt v(vcc) v(vee) v(in) v(a) v(p) v(out)
ac dec 20 10 1000000
wrdata <repo>/tests/_ngspice/sallen_key_lp/ac.txt v(out)
tran 5e-06 0.004 0 5e-06
linearize v(vcc) v(vee) v(in) v(a) v(p) v(out)
wrdata <repo>/tests/_ngspice/sallen_key_lp/tran.txt v(vcc) v(vee) v(in) v(a) v(p) v(out)
.endc
.end
