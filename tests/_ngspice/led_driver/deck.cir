* Transistor LED driver switched by a pulse (generated for the Hotwire cross-check)
VCC vcc 0 DC 9
VIN in 0 DC 5 PULSE(0 5 0.0002 1e-06 1e-06 0.0005 0.001)
RB in b 10000
Q1 c b 0 Q2N3904
RL vcc a 390
D1 a c LEDR
.model LEDR D(IS=9.32e-11 N=3.73 RS=2 CJO=2e-11)
.model Q2N3904 NPN(IS=6.734e-15 BF=416.4 BR=0.7371 NF=1 NR=1 VAF=74.03 IKF=0.06678 ISE=6.734e-15 NE=1.259 RB=10 RC=1 CJE=4.493e-12 MJE=0.2593 VJE=0.75 CJC=3.638e-12 MJC=0.3085 VJC=0.75 TF=3.012e-10 TR=2.395e-07)
.options rshunt=1e12 reltol=1e-6 abstol=1e-15 vntol=1e-9 itl1=500 itl4=200
.control
set wr_singlescale
set wr_vecnames
option numdgt=12
op
wrdata <repo>/tests/_ngspice/led_driver/op.txt v(vcc) v(in) v(b) v(c) v(a)
tran 2e-06 0.002 0 2e-06
linearize v(vcc) v(in) v(b) v(c) v(a)
wrdata <repo>/tests/_ngspice/led_driver/tran.txt v(vcc) v(in) v(b) v(c) v(a)
.endc
.end
