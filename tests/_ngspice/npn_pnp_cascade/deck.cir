* NPN emitter follower driving a PNP common-emitter stage (generated for the Hotwire cross-check)
VCC vcc 0 DC 12
VIN in 0 DC 0 AC 1 SIN(0 0.05 2000 0 0)
C1 in b1 1e-06
R1 vcc b1 150000
R2 b1 0 100000
Q1 vcc b1 e1 Q2N3904
RE1 e1 0 4700
Q2 c2 bp e2 Q2N3906
RB2 vcc bp 47000
CB2 e1 bp 1e-06
RB3 bp 0 100000
RE2 vcc e2 3300
CE2 vcc e2 1e-05
RC2 c2 0 4700
C2 c2 out 1e-06
RL out 0 47000
.model Q2N3904 NPN(IS=6.734e-15 BF=416.4 BR=0.7371 NF=1 NR=1 VAF=74.03 IKF=0.06678 ISE=6.734e-15 NE=1.259 RB=10 RC=1 CJE=4.493e-12 MJE=0.2593 VJE=0.75 CJC=3.638e-12 MJC=0.3085 VJC=0.75 TF=3.012e-10 TR=2.395e-07)
.model Q2N3906 PNP(IS=1.41e-15 BF=180.7 BR=4.977 NF=1 NR=1 VAF=18.7 IKF=0.08 ISE=0 RB=10 RC=2.5 CJE=8.063e-12 MJE=0.3677 VJE=0.75 CJC=4.017e-12 MJC=0.5 VJC=0.75 TF=5.133e-10 TR=3.342e-08)
.options rshunt=1e12 reltol=1e-6 abstol=1e-15 vntol=1e-9 itl1=500 itl4=200
.control
set wr_singlescale
set wr_vecnames
option numdgt=12
op
wrdata <repo>/tests/_ngspice/npn_pnp_cascade/op.txt v(vcc) v(in) v(b1) v(e1) v(c2) v(bp) v(e2) v(out)
ac dec 20 10 1000000
wrdata <repo>/tests/_ngspice/npn_pnp_cascade/ac.txt v(out)
tran 5e-06 0.003 0 5e-06
linearize v(vcc) v(in) v(b1) v(e1) v(c2) v(bp) v(e2) v(out)
wrdata <repo>/tests/_ngspice/npn_pnp_cascade/tran.txt v(vcc) v(in) v(b1) v(e1) v(c2) v(bp) v(e2) v(out)
.endc
.end
