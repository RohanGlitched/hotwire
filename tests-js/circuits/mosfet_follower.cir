*@ title P-channel source follower
*@ in VIN
*@ out out
*@ supply VCC
VCC vcc 0 DC 9
VIN in 0 DC 0 AC 1
C1 in g 100n
R1 vcc g 1meg
R2 g 0 1meg
RS vcc s 2.2k
M1 0 g s BS250
C2 s out 4.7u
RL out 0 47k
