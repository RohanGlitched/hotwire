*@ title JFET booster
*@ in VIN
*@ out out
*@ supply VCC
VCC vcc 0 DC 9
VIN in 0 DC 0 AC 1
C1 in g 100n
RG g 0 1meg
J1 d g s J201
RD vcc d 6.8k
RS s 0 1k
CS s 0 22u
C2 d out 1u
RL out 0 100k
