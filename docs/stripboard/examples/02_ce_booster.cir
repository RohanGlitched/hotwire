*@ title Common-emitter clean booster
* Single 2N3904 stage with a divider bias, a bypassed emitter and a 1 meg output pull-down.
*@ in VIN
*@ out out
*@ supply VCC
VCC vcc 0 DC 9
VIN in 0 DC 0 AC 1
C1 in b 100n
R1 vcc b 470k
R2 b 0 82k
Q1 c b e 2N3904
RC vcc c 10k
RE e 0 1k
CE e 0 22u
C2 c out 1u
R3 out 0 1meg
.end
