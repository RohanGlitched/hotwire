*@ title JFET clean boost
* MPF102 common-source stage with partial source bypass: about +15 dB of clean-ish gain with a touch of warm even-order harmonics, then a level knob.
*@ in VIN
*@ out out
*@ supply VCC
*@ pot RV1 0 out o 100k taper=log pos=1 label="Level"
*@ spec gain_db(1000) in 12..20 dB
*@ spec gain_db(30) > 12 dB
*@ spec gain_db(10000) > 12 dB
*@ spec v(d) in 4..7 V
*@ spec region(J1) == saturation
*@ spec thd(1000, 0.1) < 3 %
*@ spec supply_current < 2mA
VIN in 0 DC 0 AC 1
VCC vcc 0 DC 9
RPD in 0 1meg
C1 in g 100n
RG g 0 1meg
J1 d g s MPF102
RD vcc d 4.7k
RS1 s s2 100
RS2 s2 0 2k
CS s2 0 47u
C2 d o 1u
.end
