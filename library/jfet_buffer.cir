*@ title JFET input buffer
* J201 source follower with a 1 M input impedance: unity gain, keeps the guitar's treble intact through long cables; it should sound like nothing at all.
*@ in VIN
*@ out out
*@ supply VCC
*@ spec gain_db(1000) in -1..0 dB
*@ spec gain_db(20) > -1.5 dB
*@ spec gain_db(20000) > -1 dB
*@ spec v(s) in 4..6 V
*@ spec region(J1) == saturation
*@ spec thd(1000, 2) < 1 %
*@ spec supply_current < 1mA
VIN in 0 DC 0 AC 1
VCC vcc 0 DC 9
RPD in 0 2.2meg
C1 in g 100n
RG g vb 1meg
RB1 vcc vb 1meg
RB2 vb 0 1meg
CB vb 0 10u
RD vcc d 100
CD d 0 47u
J1 d g s J201
RS s 0 22k
C2 s out 1u
RL out 0 100k
.end
